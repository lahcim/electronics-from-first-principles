* Lesson 3 - Voltage Is a Difference
V2 MID 0 3
V1 TOP MID 5
.op
.end
