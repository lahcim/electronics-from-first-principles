* Lesson 12 - Loaded divider
V1 VIN 0 12
R1 VIN VOUT 10k
R2 VOUT 0 10k
RL VOUT 0 10k
.op
.end
