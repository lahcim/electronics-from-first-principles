* Volume 2 Lesson 27 - RC pulse shaping
V1 IN 0 PULSE(0 5 0 100n 100n 1m 10m)
RINT IN VINT 100k
CINT VINT 0 1u
CDIFF IN VDIFF 10n
RDIFF VDIFF 0 10k
.tran 2u 30m startup
.end
