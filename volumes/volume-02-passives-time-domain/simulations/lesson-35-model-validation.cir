* Lesson 35 - Simplified capacitor validation fixture
V1 IN 0 AC 1
RTEST IN N0 1m
LESL N0 N1 1n
RESR N1 N2 50m
C1 N2 0 10u
RLEAK N2 0 100Meg
.ac dec 100 100 100Meg
.end
