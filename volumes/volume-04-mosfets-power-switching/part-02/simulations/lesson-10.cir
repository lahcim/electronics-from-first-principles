* Lesson 10 - MOSFET switching loss cell
V1 BUS 0 48
RLOAD BUS D 6
M1 D G 0 0 NM
VDRV DRV 0 PULSE(0 10 100n 10n 10n 2u 5u)
RG DRV G 10
.model NM NMOS(VTO=2.5 KP=80 RD=6m RS=6m CGS=2n CGD=400p CBD=200p)
.tran 100p 15u startup
.meas tran EON INTEG V(D)*I(M1) FROM=90n TO=250n
.end
